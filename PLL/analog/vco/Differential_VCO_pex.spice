* NGSPICE file created from VCO_PEX.ext - technology: gf180mcuE

.subckt VCO_PEX VDD VBUF VSS O1P O1N O2P O2N O3P O3N O4P O4N DOUBLE_OUT VTUNE TAIL_BIAS
+ PRESCALER_CLK
X0 N6.t0 N3.t3 VSS.t6 VSS.t5 nfet_03v3 ad=0.61p pd=3.22u as=0.61p ps=3.22u w=1u l=0.28u
X1 VBUF.t11 N3.t4 N6.t1 VBUF.t10 pfet_03v3 ad=1.3p pd=5.3u as=1.3p ps=5.3u w=2u l=0.28u
X2 VSS.t46 O4N.t4 O4P.t1 VSS.t45 nfet_03v3 ad=0.4697p pd=2.76u as=0.4697p ps=2.76u w=0.77u l=0.28u
X3 N5.t1 RAW cap_mim_2f0_m5m6_noshield c_width=5u c_length=5u
D0 O1P.t8 RAW.t0 sc_diode pj=4.47u area=1.0013p
X4 N3.t1 N5.t2 VSS.t34 VSS.t33 nfet_03v3 ad=0.61p pd=3.22u as=0.61p ps=3.22u w=1u l=0.28u
X5 VBUF.t9 a_1449_1346.t3 DBUF_SENSE.t1 VBUF.t8 pfet_03v3 ad=1.3p pd=5.3u as=1.3p ps=5.3u w=2u l=0.28u
X6 VBUF.t7 DBUF_SENSE.t3 PRESCALER_CLK.t1 VBUF.t6 pfet_03v3 ad=1.3p pd=5.3u as=1.3p ps=5.3u w=2u l=0.28u
X7 VSS.t49 O2N.t4 O2P.t2 VSS.t48 nfet_03v3 ad=0.4697p pd=2.76u as=0.4697p ps=2.76u w=0.77u l=0.28u
X8 VBUF.t5 N5.t3 N3.t0 VBUF.t4 pfet_03v3 ad=1.3p pd=5.3u as=1.3p ps=5.3u w=2u l=0.28u
X9 VDD.t5 O1N.t6 O3P.t1 VDD.t4 pfet_03v3 ad=1.95p pd=7.3u as=1.95p ps=7.3u w=3u l=0.28u
X10 VSS.t2 O2P.t5 O3P.t0 VSS.t1 nfet_03v3 ad=0.915p pd=4.22u as=0.915p ps=4.22u w=1.5u l=0.28u
X11 a_1449_1346.t0 O1P.t4 a_1717_718.t0 VSS.t12 nfet_03v3 ad=0.61p pd=3.22u as=0.61p ps=3.22u w=1u l=0.28u
X12 O3N.t2 O2N.t3 VSS.t51 VSS.t50 nfet_03v3 ad=0.915p pd=4.22u as=0.915p ps=4.22u w=1.5u l=0.28u
X13 O3N.t1 O1P.t3 VDD.t3 VDD.t2 pfet_03v3 ad=1.95p pd=7.3u as=1.95p ps=7.3u w=3u l=0.28u
X14 VSS.t30 O3N.t5 O3P.t2 VSS.t29 nfet_03v3 ad=0.4697p pd=2.76u as=0.4697p ps=2.76u w=0.77u l=0.28u
X15 DOUBLE_OUT.t1 N6.t2 VSS.t27 VSS.t26 nfet_03v3 ad=0.61p pd=3.22u as=0.61p ps=3.22u w=1u l=0.28u
X16 O3N.t0 O3P.t3 VSS.t41 VSS.t40 nfet_03v3 ad=0.4697p pd=2.76u as=0.4697p ps=2.76u w=0.77u l=0.28u
X17 N5.t0 N3.t2 VSS.t52 ppolyf_u r_width=0.8u r_length=28u
X18 VBUF.t3 N6.t3 DOUBLE_OUT.t0 VBUF.t2 pfet_03v3 ad=1.3p pd=5.3u as=1.3p ps=5.3u w=2u l=0.28u
X19 VTUNE.t0 O2P.t6 VTUNE.t0 VSS.t0 nfet_03v3 ad=0.61p pd=3.22u as=0 ps=0 w=1u l=0.28u
X20 VTUNE.t7 O2N.t6 VTUNE.t7 VSS.t47 nfet_03v3 ad=0.61p pd=3.22u as=0 ps=0 w=1u l=0.28u
X21 VTUNE.t1 O4P.t6 VTUNE.t1 VSS.t21 nfet_03v3 ad=0.61p pd=3.22u as=0 ps=0 w=1u l=0.28u
D1 O1N.t8 RAW.t0 sc_diode pj=4.47u area=1.0013p
X22 VTUNE.t6 O4N.t6 VTUNE.t6 VSS.t42 nfet_03v3 ad=0.61p pd=3.22u as=0 ps=0 w=1u l=0.28u
X23 VTUNE.t5 O1P.t7 VTUNE.t5 VSS.t7 nfet_03v3 ad=0.61p pd=3.22u as=0 ps=0 w=1u l=0.28u
X24 VTUNE.t4 O1N.t7 VTUNE.t4 VSS.t13 nfet_03v3 ad=0.61p pd=3.22u as=0 ps=0 w=1u l=0.28u
X25 VDD.t11 O3P.t5 O1P.t1 VDD.t10 pfet_03v3 ad=1.95p pd=7.3u as=1.95p ps=7.3u w=3u l=0.28u
X26 a_1717_718.t2 TAIL_BIAS.t0 VSS.t36 VSS.t35 nfet_03v3 ad=0.61p pd=3.22u as=0.61p ps=3.22u w=1u l=0.28u
X27 RAW VSS.t54 VSS.t53 ppolyf_u r_width=0.8u r_length=28u
X28 VDD.t7 O4P.t5 O2P.t0 VDD.t6 pfet_03v3 ad=1.95p pd=7.3u as=1.95p ps=7.3u w=3u l=0.28u
X29 VSS.t15 O1N.t5 O1P.t0 VSS.t14 nfet_03v3 ad=0.4697p pd=2.76u as=0.4697p ps=2.76u w=0.77u l=0.28u
X30 VSS.t9 O1P.t6 O2P.t1 VSS.t8 nfet_03v3 ad=0.915p pd=4.22u as=0.915p ps=4.22u w=1.5u l=0.28u
X31 O4N.t0 O2P.t3 VDD.t1 VDD.t0 pfet_03v3 ad=1.95p pd=7.3u as=1.95p ps=7.3u w=3u l=0.28u
X32 VTUNE.t2 O3N.t6 VTUNE.t2 VSS.t28 nfet_03v3 ad=0.61p pd=3.22u as=0 ps=0 w=1u l=0.28u
X33 O1N.t2 O3N.t3 VDD.t9 VDD.t8 pfet_03v3 ad=1.95p pd=7.3u as=1.95p ps=7.3u w=3u l=0.28u
X34 O1N.t1 O4P.t4 VSS.t23 VSS.t22 nfet_03v3 ad=0.915p pd=4.22u as=0.915p ps=4.22u w=1.5u l=0.28u
X35 O2N.t0 O4N.t3 VDD.t13 VDD.t12 pfet_03v3 ad=1.95p pd=7.3u as=1.95p ps=7.3u w=3u l=0.28u
X36 VSS.t44 O4N.t5 O1P.t2 VSS.t43 nfet_03v3 ad=0.915p pd=4.22u as=0.915p ps=4.22u w=1.5u l=0.28u
X37 O2N.t2 O2P.t4 VSS.t4 VSS.t3 nfet_03v3 ad=0.4697p pd=2.76u as=0.4697p ps=2.76u w=0.77u l=0.28u
X38 VBUF.t1 a_1449_1346.t1 a_1449_1346.t2 VBUF.t0 pfet_03v3 ad=1.3p pd=5.3u as=1.3p ps=5.3u w=2u l=0.28u
X39 O4N.t1 O4P.t3 VSS.t25 VSS.t24 nfet_03v3 ad=0.4697p pd=2.76u as=0.4697p ps=2.76u w=0.77u l=0.28u
X40 VDD.t15 O2N.t5 O4P.t2 VDD.t14 pfet_03v3 ad=1.95p pd=7.3u as=1.95p ps=7.3u w=3u l=0.28u
X41 DBUF_SENSE.t0 O1N.t4 a_1717_718.t1 VSS.t16 nfet_03v3 ad=0.61p pd=3.22u as=0.61p ps=3.22u w=1u l=0.28u
X42 O2N.t1 O1N.t3 VSS.t18 VSS.t17 nfet_03v3 ad=0.915p pd=4.22u as=0.915p ps=4.22u w=1.5u l=0.28u
X43 PRESCALER_CLK.t0 DBUF_SENSE.t2 VSS.t20 VSS.t19 nfet_03v3 ad=0.61p pd=3.22u as=0.61p ps=3.22u w=1u l=0.28u
X44 VTUNE.t3 O3P.t6 VTUNE.t3 VSS.t37 nfet_03v3 ad=0.61p pd=3.22u as=0 ps=0 w=1u l=0.28u
X45 VSS.t39 O3P.t4 O4P.t0 VSS.t38 nfet_03v3 ad=0.915p pd=4.22u as=0.915p ps=4.22u w=1.5u l=0.28u
X46 O4N.t2 O3N.t4 VSS.t32 VSS.t31 nfet_03v3 ad=0.915p pd=4.22u as=0.915p ps=4.22u w=1.5u l=0.28u
X47 O1N.t0 O1P.t5 VSS.t11 VSS.t10 nfet_03v3 ad=0.4697p pd=2.76u as=0.4697p ps=2.76u w=0.77u l=0.28u
R0 TAIL_BIAS TAIL_BIAS.t0 46.0204
R1 PRESCALER_CLK PRESCALER_CLK.t0 22.7867
R2 PRESCALER_CLK PRESCALER_CLK.t1 16.7123
R3 O3N.n5 O3N.t3 67.5941
R4 O3N.n3 O3N.t6 53.2315
R5 O3N.n4 O3N.t4 48.3591
R6 O3N.n0 O3N.t5 30.3911
R7 O3N.n4 O3N.n3 10.362
R8 O3N.n2 O3N.t0 9.5991
R9 O3N.n3 O3N.n2 9.05503
R10 O3N.n0 O3N.t2 4.8305
R11 O3N O3N.n5 4.5005
R12 O3N.n5 O3N.n4 4.3205
R13 O3N.n1 O3N.t1 3.02998
R14 O3N.n2 O3N.n1 0.29619
R15 O3N.n1 O3N.n0 0.200271
R16 O2N.n4 O2N.t5 70.2801
R17 O2N.n0 O2N.t3 59.8769
R18 O2N.n0 O2N.t6 53.1701
R19 O2N.n1 O2N.t4 30.3911
R20 O2N.n3 O2N.t2 9.5991
R21 O2N.n4 O2N.n3 9.0185
R22 O2N.n1 O2N.t1 4.8305
R23 O2N O2N.n4 4.5005
R24 O2N.n2 O2N.t0 3.02998
R25 O2N.n3 O2N.n2 0.29619
R26 O2N.n2 O2N.n1 0.200271
R27 O2N.n4 O2N.n0 0.1805
R28 O2P O2P.t3 73.8182
R29 O2P.n0 O2P.t6 52.4202
R30 O2P.n0 O2P.t5 49.1975
R31 O2P.n2 O2P.t4 30.4028
R32 O2P.n1 O2P.t2 9.93287
R33 O2P.n3 O2P.n2 9.01482
R34 O2P.n2 O2P.t1 4.8305
R35 O2P O2P.n3 4.5005
R36 O2P.n1 O2P.t0 3.05439
R37 O2P.n2 O2P.n1 0.192158
R38 O2P.n3 O2P.n0 0.1805
R39 O4N.n0 O4N.t3 87.7522
R40 O4N.n0 O4N.t6 52.5859
R41 O4N O4N.t5 52.5273
R42 O4N.n1 O4N.t4 30.3911
R43 O4N O4N.n4 9.9755
R44 O4N.n3 O4N.t1 9.5991
R45 O4N.n4 O4N.n3 9.01962
R46 O4N.n1 O4N.t2 4.8305
R47 O4N.n2 O4N.t0 3.02998
R48 O4N.n4 O4N.n0 0.7505
R49 O4N.n3 O4N.n2 0.29619
R50 O4N.n2 O4N.n1 0.200271
R51 O4P.n2 O4P.t5 73.8509
R52 O4P O4P.t4 52.5443
R53 O4P.n2 O4P.t6 46.8699
R54 O4P.n1 O4P.t3 30.4028
R55 O4P.n3 O4P.n1 14.6411
R56 O4P O4P.n3 12.3755
R57 O4P.n0 O4P.t1 9.93287
R58 O4P.n1 O4P.t0 4.8305
R59 O4P.n0 O4P.t2 3.05439
R60 O4P.n3 O4P.n2 1.0805
R61 O4P.n1 O4P.n0 0.192158
R62 O3P.n4 O3P.t5 67.6257
R63 O3P.n3 O3P.t4 57.4776
R64 O3P.n2 O3P.t6 52.2778
R65 O3P.n1 O3P.t3 30.4028
R66 O3P.n2 O3P.n1 10.0938
R67 O3P.n0 O3P.t2 9.93287
R68 O3P.n3 O3P.n2 4.8605
R69 O3P.n1 O3P.t0 4.8305
R70 O3P.n4 O3P.n3 4.11122
R71 O3P.n0 O3P.t1 3.05439
R72 O3P O3P.n4 2.26198
R73 O3P.n1 O3P.n0 0.192158
R74 VTUNE.n0 VTUNE.t3 23.5505
R75 VTUNE.n0 VTUNE.t2 14.1981
R76 VTUNE.n3 VTUNE.t6 13.7954
R77 VTUNE.n2 VTUNE.t0 13.7935
R78 VTUNE.n4 VTUNE.t1 13.7923
R79 VTUNE.n1 VTUNE.t7 13.7919
R80 VTUNE.n5 VTUNE.t4 13.6991
R81 VTUNE.n6 VTUNE.t5 13.6912
R82 VTUNE VTUNE.n6 4.5005
R83 VTUNE.n5 VTUNE.n4 2.67736
R84 VTUNE.n1 VTUNE.n0 1.1705
R85 VTUNE.n4 VTUNE.n3 0.9905
R86 VTUNE.n2 VTUNE.n1 0.8105
R87 VTUNE.n3 VTUNE.n2 0.8105
R88 VTUNE.n6 VTUNE.n5 0.772882
R89 DOUBLE_OUT DOUBLE_OUT.n0 13.5046
R90 DOUBLE_OUT.n0 DOUBLE_OUT.t1 8.8205
R91 DOUBLE_OUT.n0 DOUBLE_OUT.t0 3.79614
R92 O1N.n4 O1N.t6 73.746
R93 O1N.n4 O1N.t3 52.7677
R94 O1N.n5 O1N.t4 46.0645
R95 O1N.n3 O1N.t7 46.0584
R96 O1N.n0 O1N.t5 30.3911
R97 O1N.n3 O1N.t8 15.3417
R98 O1N.n5 O1N.n4 14.4455
R99 O1N.n2 O1N.t0 9.5991
R100 O1N.n7 O1N.n2 9.0494
R101 O1N.n7 O1N.n6 6.93122
R102 O1N.n0 O1N.t1 4.8305
R103 O1N.n1 O1N.t2 3.02998
R104 O1N O1N.n7 2.26198
R105 O1N.n6 O1N.n3 1.2455
R106 O1N.n6 O1N.n5 0.8555
R107 O1N.n2 O1N.n1 0.29619
R108 O1N.n1 O1N.n0 0.200271
R109 O1P.n0 O1P.t3 75.5271
R110 O1P.n2 O1P.t7 46.0139
R111 O1P.n0 O1P.t6 43.527
R112 O1P.n3 O1P.t4 41.5186
R113 O1P.n5 O1P.t5 30.4028
R114 O1P.n1 O1P.n0 24.7505
R115 O1P.n1 O1P.t8 14.3217
R116 O1P.n4 O1P.t0 9.93287
R117 O1P O1P.n6 9.0005
R118 O1P.n3 O1P.n2 6.2555
R119 O1P.n6 O1P.n3 6.2488
R120 O1P.n5 O1P.t2 4.8305
R121 O1P.n6 O1P.n5 4.51199
R122 O1P.n4 O1P.t1 3.05439
R123 O1P.n2 O1P.n1 1.3955
R124 O1P.n5 O1P.n4 0.192158
R125 VDD.n3 VDD.t12 915.008
R126 VDD.n12 VDD.t8 914.922
R127 VDD.n2 VDD.t0 914.83
R128 VDD.n7 VDD.t6 914.588
R129 VDD.n11 VDD.t10 914.543
R130 VDD.n10 VDD.t14 914.543
R131 VDD.n1 VDD.t2 910.105
R132 VDD.n0 VDD.t4 910.067
R133 VDD.n1 VDD.t3 18.0127
R134 VDD.n0 VDD.t5 17.9825
R135 VDD VDD.t11 15.5315
R136 VDD.n12 VDD.t9 15.5271
R137 VDD.n2 VDD.t1 15.5264
R138 VDD.n11 VDD.n10 14.5355
R139 VDD.n9 VDD.t15 11.0761
R140 VDD.n8 VDD.t7 11.0754
R141 VDD.n4 VDD.n3 9.18601
R142 VDD.n6 VDD.n5 6.6755
R143 VDD.n4 VDD.t13 6.5205
R144 VDD.n5 VDD.n1 5.5799
R145 VDD.n7 VDD.n6 5.2655
R146 VDD VDD.n12 3.0755
R147 VDD.n10 VDD.n9 2.39698
R148 VDD.n8 VDD.n7 2.30698
R149 VDD.n9 VDD.n8 1.7093
R150 VDD.n3 VDD.n2 1.3955
R151 VDD.n6 VDD.n0 0.923059
R152 VDD.n5 VDD.n4 0.746474
R153 VDD VDD.n11 0.2705
R154 VBUF.t0 VBUF.t8 1382.11
R155 VBUF.n5 VBUF.t2 1027.07
R156 VBUF.n6 VBUF.t10 1027.07
R157 VBUF.n4 VBUF.t6 1024.62
R158 VBUF.n0 VBUF.t4 1020.15
R159 VBUF.n2 VBUF.t0 593.038
R160 VBUF.n3 VBUF.t8 593.038
R161 VBUF.n2 VBUF.n1 18.325
R162 VBUF.n4 VBUF.t7 17.0358
R163 VBUF.n5 VBUF.t3 12.2534
R164 VBUF.n6 VBUF.t11 12.2533
R165 VBUF.n9 VBUF.t5 12.2075
R166 VBUF.n8 VBUF.n4 8.5505
R167 VBUF.n4 VBUF.n3 5.3555
R168 VBUF VBUF.n9 4.5005
R169 VBUF.n1 VBUF.t9 4.25543
R170 VBUF.n1 VBUF.t1 3.23598
R171 VBUF VBUF.n0 2.41893
R172 VBUF.n7 VBUF.n5 1.3049
R173 VBUF.n8 VBUF.n7 1.2605
R174 VBUF.n3 VBUF.n2 0.7655
R175 VBUF.n9 VBUF.n8 0.0905
R176 VBUF.n7 VBUF.n6 0.0449024
R177 VBUF.n8 VBUF.n0 0.0229512
R178 VSS.n9 VSS.n8 9788.24
R179 VSS.n2 VSS.n0 7067.43
R180 VSS.n60 VSS.t12 6250.2
R181 VSS.t29 VSS.n25 6164.17
R182 VSS.n8 VSS.n6 4997.39
R183 VSS.n41 VSS.n40 4113.67
R184 VSS.n39 VSS.n24 4113.67
R185 VSS.n38 VSS.n37 3987.21
R186 VSS.t7 VSS.n60 3378.28
R187 VSS.n8 VSS.t13 3332.37
R188 VSS.n36 VSS.n34 3218.49
R189 VSS.n44 VSS.n22 3218.49
R190 VSS.n40 VSS.n39 2985.62
R191 VSS.t53 VSS.n62 2094.68
R192 VSS.n40 VSS.n7 2042.61
R193 VSS.n37 VSS.n36 1971.97
R194 VSS.t0 VSS.n22 1590.05
R195 VSS.n42 VSS.n23 1405.97
R196 VSS.n34 VSS.t48 1342.13
R197 VSS.n44 VSS.t45 1342.13
R198 VSS.t16 VSS.n9 1205.18
R199 VSS.t19 VSS.n6 1153.78
R200 VSS.n33 VSS.t40 1152.55
R201 VSS.n45 VSS.t3 1152.55
R202 VSS.t1 VSS.t50 1083.33
R203 VSS.t17 VSS.t8 1083.33
R204 VSS.t31 VSS.t38 1083.33
R205 VSS.t22 VSS.t43 1083.33
R206 VSS.t26 VSS.n35 1023.43
R207 VSS.n43 VSS.t21 1009.07
R208 VSS.n42 VSS.n41 963.519
R209 VSS.t12 VSS.t35 908.173
R210 VSS.t35 VSS.t16 851.054
R211 VSS.t10 VSS.n0 848.611
R212 VSS.t42 VSS.n11 846.198
R213 VSS.t52 VSS.n7 810.717
R214 VSS.n9 VSS.t19 782.514
R215 VSS.n39 VSS.n38 739.73
R216 VSS.n62 VSS.n61 734.423
R217 VSS.n25 VSS.t37 701.422
R218 VSS.t47 VSS.t26 666.476
R219 VSS.t7 VSS.t13 584.92
R220 VSS.n62 VSS.n2 544.775
R221 VSS.t53 VSS.t13 523.817
R222 VSS.n55 VSS.n7 405.546
R223 VSS.t24 VSS.n43 394.214
R224 VSS.n60 VSS.t14 334.029
R225 VSS VSS.n0 328.738
R226 VSS.n37 VSS.t37 324.502
R227 VSS.t50 VSS.t29 261.807
R228 VSS.t40 VSS.t1 261.807
R229 VSS.t48 VSS.t17 261.807
R230 VSS.t8 VSS.t3 261.807
R231 VSS.t45 VSS.t31 261.807
R232 VSS.t38 VSS.t24 261.807
R233 VSS.t14 VSS.t22 261.807
R234 VSS.t43 VSS.t10 261.807
R235 VSS.n34 VSS.n33 252.779
R236 VSS.n45 VSS.n44 252.779
R237 VSS.n68 VSS.n3 247.722
R238 VSS.n64 VSS.n3 247.722
R239 VSS.n68 VSS.n4 247.625
R240 VSS.n64 VSS.n4 247.625
R241 VSS.t21 VSS.n42 234.639
R242 VSS.n69 VSS.n2 230.672
R243 VSS.n25 VSS.t28 212.174
R244 VSS.n36 VSS.t47 204.685
R245 VSS.n56 VSS.t33 184.381
R246 VSS.t5 VSS.t42 177.227
R247 VSS.n63 VSS.n6 146.309
R248 VSS.n35 VSS.n24 117.32
R249 VSS.n41 VSS.n11 117.32
R250 VSS.n56 VSS.n55 114.725
R251 VSS.n54 VSS.n6 72.3441
R252 VSS.t52 VSS.t53 60.1805
R253 VSS.n22 VSS.t5 49.9237
R254 VSS.n63 VSS.t52 41.638
R255 VSS.n54 VSS.n53 33.2257
R256 VSS.n46 VSS.n45 28.8934
R257 VSS.n70 VSS.n69 27.1102
R258 VSS.t35 VSS.n59 26.4339
R259 VSS.n13 VSS.t54 24.5255
R260 VSS.n55 VSS.n54 24.478
R261 VSS.n38 VSS.n13 24.2302
R262 VSS.n51 VSS.n11 23.9605
R263 VSS.n35 VSS.n12 23.9602
R264 VSS.n72 VSS.t15 23.4006
R265 VSS.n17 VSS.t46 23.4006
R266 VSS.n27 VSS.t30 23.4006
R267 VSS.n71 VSS.t11 23.3466
R268 VSS.n16 VSS.t25 23.3466
R269 VSS.n29 VSS.t4 23.3466
R270 VSS.n26 VSS.t41 23.3466
R271 VSS.n31 VSS.t49 23.1972
R272 VSS.n12 VSS.t27 22.7828
R273 VSS.n52 VSS.t34 22.3334
R274 VSS.n50 VSS.t6 22.3331
R275 VSS.n58 VSS.t20 22.3306
R276 VSS.n33 VSS.n32 19.8591
R277 VSS.n71 VSS.t23 18.56
R278 VSS.n16 VSS.t32 18.56
R279 VSS.n29 VSS.t18 18.56
R280 VSS.n26 VSS.t51 18.56
R281 VSS.n64 VSS.n63 18.3229
R282 VSS.n59 VSS.t36 17.8782
R283 VSS.n53 VSS.n1 16.3805
R284 VSS.n23 VSS.t33 15.8261
R285 VSS.n57 VSS.n56 14.9143
R286 VSS.n73 VSS.t44 13.835
R287 VSS.n48 VSS.n13 12.0155
R288 VSS.n21 VSS.t9 11.6172
R289 VSS.n28 VSS.t2 11.6161
R290 VSS.n58 VSS.n57 10.3955
R291 VSS.n24 VSS.t0 9.98514
R292 VSS.n14 VSS.t39 9.3305
R293 VSS.n66 VSS.n1 9.01306
R294 VSS.n49 VSS.n48 9.0005
R295 VSS.n61 VSS.t7 7.20072
R296 VSS.n43 VSS.n23 6.23135
R297 VSS.n59 VSS.n58 6.03122
R298 VSS.n70 VSS.n1 5.7605
R299 VSS.n47 VSS.n20 5.66938
R300 VSS.n32 VSS.n31 5.2655
R301 VSS.n19 VSS.n18 4.60359
R302 VSS.n18 VSS.n15 4.5005
R303 VSS.n15 VSS.n14 4.5005
R304 VSS.n19 VSS.n10 4.5005
R305 VSS.n47 VSS.n46 4.5005
R306 VSS.n67 VSS.n5 3.1855
R307 VSS.n65 VSS.n5 3.1855
R308 VSS.n67 VSS.n66 3.17925
R309 VSS.n66 VSS.n65 3.17925
R310 VSS.n28 VSS.n27 2.45684
R311 VSS.n30 VSS.n21 2.3183
R312 VSS.n48 VSS.n47 1.8905
R313 VSS VSS.n70 1.20963
R314 VSS.n57 VSS.n10 0.941964
R315 VSS.n52 VSS.n51 0.8105
R316 VSS.n72 VSS.n71 0.761
R317 VSS.n17 VSS.n16 0.761
R318 VSS.n30 VSS.n29 0.761
R319 VSS.n27 VSS.n26 0.761
R320 VSS.n49 VSS.n12 0.6305
R321 VSS.n32 VSS.n28 0.526838
R322 VSS.n46 VSS.n21 0.464005
R323 VSS.n51 VSS.n50 0.4505
R324 VSS.n53 VSS.n52 0.4505
R325 VSS.n65 VSS.n64 0.289389
R326 VSS.n68 VSS.n67 0.289389
R327 VSS.n69 VSS.n68 0.289389
R328 VSS.n73 VSS.n72 0.1807
R329 VSS.n50 VSS.n49 0.1805
R330 VSS.n18 VSS.n17 0.176
R331 VSS.n5 VSS.n3 0.149071
R332 VSS.n61 VSS.n3 0.149071
R333 VSS.n66 VSS.n4 0.149071
R334 VSS.n61 VSS.n4 0.149071
R335 VSS.n20 VSS.n15 0.10175
R336 VSS.n14 VSS.n10 0.101194
R337 VSS.n31 VSS.n30 0.0673571
R338 VSS VSS.n73 0.0637319
R339 VSS.n20 VSS.n19 0.001625
R340 a_1717_718.t0 a_1717_718.n0 9.41255
R341 a_1717_718.n0 a_1717_718.t2 9.21065
R342 a_1717_718.n0 a_1717_718.t1 9.37342
R343 DBUF_SENSE.t0 DBUF_SENSE.n0 8.8205
R344 DBUF_SENSE.n0 DBUF_SENSE.t1 3.68757
R345 DBUF_SENSE DBUF_SENSE.n0 13.5171
R346 DBUF_SENSE DBUF_SENSE.n1 14.461
R347 DBUF_SENSE.n1 DBUF_SENSE.t2 33.4534
R348 DBUF_SENSE.n1 DBUF_SENSE.t3 45.5434
R349 a_1449_1346.t0 a_1449_1346.n0 9.015
R350 a_1449_1346.n0 a_1449_1346.n1 1.09891
R351 a_1449_1346.n1 a_1449_1346.t3 56.5567
R352 a_1449_1346.n1 a_1449_1346.t1 45.5434
R353 a_1449_1346.n0 a_1449_1346.t2 3.40583
R354 N6.t0 N6.n0 8.8205
R355 N6.n0 N6.t1 3.79614
R356 N6 N6.n0 13.5047
R357 N6 N6.n1 14.8784
R358 N6.n1 N6.t2 33.4534
R359 N6.n1 N6.t3 45.5434
R360 N3.t2 N3.n2 26.9124
R361 N3 N3.n2 1.3205
R362 N3 N3.n1 13.5048
R363 N3.n1 N3.t0 3.79614
R364 N3.n1 N3.t1 8.8205
R365 N3.n2 N3.n0 13.5137
R366 N3.n0 N3.t3 33.4534
R367 N3.n0 N3.t4 45.5434
R368 N5.n1 N5.t0 34.3812
R369 N5 N5.n1 6.30057
R370 N5 N5.t1 9.43578
R371 N5.n1 N5.n0 9.05907
R372 N5.n0 N5.t2 33.4534
R373 N5.n0 N5.t3 45.5434
R374 RAW RAW.t0 0.0005
C0 VTUNE O1P 0.46141f
C1 VBUF N3 0.67818f
C2 O2N O4N 0.46834f
C3 RAW O1P 0.82744f
C4 VDD O1N 1.23419f
C5 O3P O2P 0.19754f
C6 O3N O1P 0.41846f
C7 VDD VBUF 0.09337f
C8 VTUNE O1N 0.32762f
C9 O1N RAW 0.73312f
C10 O4P PRESCALER_CLK 0.02258f
C11 O3P O4N 0.13453f
C12 VTUNE VBUF 0.21728f
C13 O1N O3N 0.8562f
C14 VBUF RAW 0.65906f
C15 VBUF N6 0.33337f
C16 VTUNE N3 0.01226f
C17 RAW N3 0.13598f
C18 N3 N6 0.30726f
C19 DBUF_SENSE O3N 0.03243f
C20 O4P O1P 0.34082f
C21 VDD VTUNE 1.30665f
C22 VDD RAW 0.07249f
C23 O2P O4N 0.2402f
C24 O4P O1N 0.52166f
C25 O2N O1P 0.89533f
C26 VDD O3N 1.14814f
C27 DOUBLE_OUT VBUF 0.15179f
C28 VTUNE RAW 0.01716f
C29 VTUNE N6 0.02346f
C30 VBUF O4P 0.82668f
C31 RAW N6 0.02045f
C32 VTUNE O3N 0.34342f
C33 O1N O2N 0.47923f
C34 O4P DBUF_SENSE 0.06063f
C35 O3P O1P 0.21023f
C36 VBUF O2N 0.01592f
C37 VDD O4P 1.31532f
C38 O1N O3P 0.38017f
C39 PRESCALER_CLK O4N 0.13059f
C40 VTUNE O4P 0.21706f
C41 DOUBLE_OUT N6 0.1875f
C42 O4P RAW 0.01453f
C43 VBUF O3P 0.54301f
C44 VDD O2N 0.71012f
C45 O1P O2P 0.57675f
C46 O4P O3N 0.0288f
C47 VTUNE O2N 0.25281f
C48 O1N O2P 0.20163f
C49 N5 O1P 0.24835f
C50 O2N O3N 0.5039f
C51 O1P O4N 0.77937f
C52 VDD O3P 2.17803f
C53 O1N N5 0.04826f
C54 VTUNE O3P 1.71256f
C55 O1N O4N 0.62682f
C56 VBUF N5 0.73382f
C57 VDD TAIL_BIAS 0.0196f
C58 O3P O3N 0.66265f
C59 VBUF O4N 0.06707f
C60 O4P O2N 0.57359f
C61 VDD O2P 0.83433f
C62 DBUF_SENSE O4N 0.2201f
C63 N5 N3 0.81833f
C64 VTUNE O2P 0.20023f
C65 TAIL_BIAS O3N 0.03512f
C66 VDD N5 0.02589f
C67 VDD O4N 0.92538f
C68 O3N O2P 0.29969f
C69 VBUF PRESCALER_CLK 0.22225f
C70 O4P O3P 0.74748f
C71 VTUNE N5 0.01918f
C72 VTUNE O4N 0.19344f
C73 N5 RAW 1.93396f
C74 RAW O4N 0.01491f
C75 DBUF_SENSE PRESCALER_CLK 0.24875f
C76 N5 N6 0.12025f
C77 O3P O2N 0.38364f
C78 O3N O4N 1.16751f
C79 O1N O1P 1.27147f
C80 VBUF O1P 0.17262f
C81 O4P O2P 0.07968f
C82 DBUF_SENSE O1P 0.01011f
C83 N3 O1P 0.01059f
C84 VBUF O1N 0.54149f
C85 O2N O2P 1.05664f
C86 O1N DBUF_SENSE 0.26381f
C87 O4P O4N 1.20779f
C88 VDD O1P 2.51892f
C89 VBUF DBUF_SENSE 0.36283f
C90 TAIL_BIAS VSS 0.42708f
C91 PRESCALER_CLK VSS 0.72942f
C92 O3N VSS 3.86468f
C93 O2N VSS 3.33272f
C94 O2P VSS 3.61681f
C95 O4N VSS 4.43754f
C96 O4P VSS 3.7208f
C97 O3P VSS 3.84271f
C98 VTUNE VSS 3.25264f
C99 DOUBLE_OUT VSS 0.30353f
C100 O1N VSS 4.40056f
C101 O1P VSS 5.31091f
C102 VDD VSS 16.38559f
C103 VBUF VSS 9.00682f
C104 DBUF_SENSE VSS 1.0619f
C105 N6 VSS 1.55105f
C106 N3 VSS 2.33301f
C107 N5 VSS 2.79929f
C108 RAW VSS 3.69673f
C109 RAW.t0 VSS 4.44481f
C110 N5.t0 VSS 0.10819f
C111 N5.n0 VSS 0.07534f
C112 N5.t3 VSS 0.02609f
C113 N5.t2 VSS 0.01496f
C114 N5.n1 VSS 0.72949f
C115 N5.t1 VSS 2.93952f
C116 N3.t2 VSS 0.127f
C117 N3.n0 VSS 0.19586f
C118 N3.t4 VSS 0.06521f
C119 N3.t3 VSS 0.0374f
C120 N3.n1 VSS 0.21105f
C121 N3.t1 VSS 0.07098f
C122 N3.t0 VSS 0.15184f
C123 N3.n2 VSS 0.89258f
C124 N6.t0 VSS 0.06055f
C125 N6.n0 VSS 0.18035f
C126 N6.n1 VSS 0.18506f
C127 N6.t3 VSS 0.05563f
C128 N6.t2 VSS 0.0319f
C129 N6.t1 VSS 0.12952f
C130 a_1449_1346.t0 VSS 0.09902f
C131 a_1449_1346.t2 VSS 0.18932f
C132 a_1449_1346.n0 VSS 0.33684f
C133 a_1449_1346.t1 VSS 0.08983f
C134 a_1449_1346.n1 VSS 0.56211f
C135 a_1449_1346.t3 VSS 0.1438f
C136 DBUF_SENSE.t0 VSS 0.09424f
C137 DBUF_SENSE.n0 VSS 0.28133f
C138 DBUF_SENSE.n1 VSS 0.27603f
C139 DBUF_SENSE.t3 VSS 0.08659f
C140 DBUF_SENSE.t2 VSS 0.04966f
C141 DBUF_SENSE.t1 VSS 0.19821f
C142 a_1717_718.t0 VSS 0.04349f
C143 a_1717_718.t1 VSS 0.04329f
C144 a_1717_718.t2 VSS 0.04257f
C145 a_1717_718.n0 VSS 0.13029f
C146 VBUF.t4 VSS 0.48318f
C147 VBUF.n0 VSS 0.20475f
C148 VBUF.t7 VSS 0.08457f
C149 VBUF.t6 VSS 0.48407f
C150 VBUF.t8 VSS 0.60135f
C151 VBUF.t9 VSS 0.08494f
C152 VBUF.t1 VSS 0.06476f
C153 VBUF.n1 VSS 0.14423f
C154 VBUF.t0 VSS 0.60135f
C155 VBUF.n2 VSS 0.22859f
C156 VBUF.n3 VSS 0.18652f
C157 VBUF.n4 VSS 0.7065f
C158 VBUF.t2 VSS 0.48467f
C159 VBUF.t3 VSS 0.07927f
C160 VBUF.n5 VSS 0.36703f
C161 VBUF.t10 VSS 0.48468f
C162 VBUF.t11 VSS 0.07937f
C163 VBUF.n6 VSS 0.27835f
C164 VBUF.n7 VSS 0.17042f
C165 VBUF.n8 VSS 0.30083f
C166 VBUF.t5 VSS 0.07939f
C167 VBUF.n9 VSS 0.02357f
C168 VDD.t15 VSS 0.11678f
C169 VDD.t6 VSS 0.75954f
C170 VDD.t5 VSS 0.13324f
C171 VDD.t4 VSS 0.75833f
C172 VDD.n0 VSS 0.37277f
C173 VDD.t3 VSS 0.13457f
C174 VDD.t2 VSS 0.75833f
C175 VDD.n1 VSS 0.44645f
C176 VDD.t1 VSS 0.12339f
C177 VDD.t0 VSS 0.75957f
C178 VDD.n2 VSS 0.41638f
C179 VDD.t12 VSS 0.75964f
C180 VDD.n3 VSS 0.46773f
C181 VDD.t13 VSS 0.11084f
C182 VDD.n4 VSS 0.0829f
C183 VDD.n5 VSS 0.39875f
C184 VDD.n6 VSS 0.19033f
C185 VDD.n7 VSS 0.35405f
C186 VDD.t7 VSS 0.11726f
C187 VDD.n8 VSS 0.15655f
C188 VDD.n9 VSS 0.15732f
C189 VDD.t14 VSS 0.75951f
C190 VDD.n10 VSS 0.80332f
C191 VDD.t10 VSS 0.7595f
C192 VDD.n11 VSS 0.63831f
C193 VDD.t8 VSS 0.75958f
C194 VDD.t9 VSS 0.12252f
C195 VDD.n12 VSS 0.56073f
C196 VDD.t11 VSS 0.12213f
C197 O1P.t7 VSS 0.07827f
C198 O1P.t8 VSS 0.44806f
C199 O1P.t6 VSS 0.07781f
C200 O1P.t3 VSS 0.22453f
C201 O1P.n0 VSS 2.45926f
C202 O1P.n1 VSS 2.17114f
C203 O1P.n2 VSS 0.94769f
C204 O1P.t4 VSS 0.06753f
C205 O1P.n3 VSS 0.35929f
C206 O1P.t1 VSS 0.38781f
C207 O1P.t0 VSS 0.07583f
C208 O1P.n4 VSS 0.45657f
C209 O1P.t2 VSS 0.14205f
C210 O1P.t5 VSS 0.04315f
C211 O1P.n5 VSS 0.37393f
C212 O1P.n6 VSS 0.58379f
C213 O1N.t2 VSS 0.35548f
C214 O1N.t5 VSS 0.03956f
C215 O1N.t1 VSS 0.13043f
C216 O1N.n0 VSS 0.34483f
C217 O1N.n1 VSS 0.35541f
C218 O1N.t0 VSS 0.06737f
C219 O1N.n2 VSS 0.07154f
C220 O1N.t8 VSS 0.44279f
C221 O1N.t7 VSS 0.07255f
C222 O1N.n3 VSS 0.93445f
C223 O1N.t4 VSS 0.07192f
C224 O1N.t6 VSS 0.15614f
C225 O1N.t3 VSS 0.08993f
C226 O1N.n4 VSS 2.00509f
C227 O1N.n5 VSS 1.15337f
C228 O1N.n6 VSS 0.73371f
C229 O1N.n7 VSS 0.57335f
C230 DOUBLE_OUT.t0 VSS 0.11379f
C231 DOUBLE_OUT.t1 VSS 0.05319f
C232 DOUBLE_OUT.n0 VSS 0.15874f
C233 VTUNE.t4 VSS 0.26259f
C234 VTUNE.t2 VSS 0.26863f
C235 VTUNE.t3 VSS 0.35153f
C236 VTUNE.n0 VSS 0.65053f
C237 VTUNE.t7 VSS 0.26292f
C238 VTUNE.n1 VSS 0.40577f
C239 VTUNE.t0 VSS 0.26218f
C240 VTUNE.n2 VSS 0.35943f
C241 VTUNE.t6 VSS 0.26144f
C242 VTUNE.n3 VSS 0.38035f
C243 VTUNE.t1 VSS 0.26273f
C244 VTUNE.n4 VSS 0.61788f
C245 VTUNE.n5 VSS 0.51279f
C246 VTUNE.t5 VSS 0.2618f
C247 VTUNE.n6 VSS 0.18915f
C248 O3P.t5 VSS 0.15302f
C249 O3P.t1 VSS 0.39794f
C250 O3P.t2 VSS 0.07781f
C251 O3P.n0 VSS 0.46849f
C252 O3P.t0 VSS 0.14576f
C253 O3P.t3 VSS 0.04428f
C254 O3P.n1 VSS 0.42612f
C255 O3P.t6 VSS 0.1633f
C256 O3P.n2 VSS 2.11819f
C257 O3P.t4 VSS 0.12142f
C258 O3P.n3 VSS 2.0231f
C259 O3P.n4 VSS 0.95865f
C260 O4P.t2 VSS 0.43205f
C261 O4P.t1 VSS 0.08449f
C262 O4P.n0 VSS 0.50866f
C263 O4P.t0 VSS 0.15826f
C264 O4P.t3 VSS 0.04807f
C265 O4P.n1 VSS 0.47366f
C266 O4P.t6 VSS 0.09378f
C267 O4P.t5 VSS 0.21282f
C268 O4P.n2 VSS 1.61183f
C269 O4P.n3 VSS 1.46968f
C270 O4P.t4 VSS 0.10766f
C271 O4N.t5 VSS 0.09784f
C272 O4N.t3 VSS 0.29453f
C273 O4N.t6 VSS 0.17153f
C274 O4N.n0 VSS 1.86392f
C275 O4N.t0 VSS 0.38432f
C276 O4N.t4 VSS 0.04277f
C277 O4N.t2 VSS 0.14101f
C278 O4N.n1 VSS 0.37281f
C279 O4N.n2 VSS 0.38424f
C280 O4N.t1 VSS 0.07283f
C281 O4N.n3 VSS 0.07972f
C282 O4N.n4 VSS 1.50425f
C283 O2P.t6 VSS 0.1294f
C284 O2P.t5 VSS 0.08286f
C285 O2P.n0 VSS 1.20064f
C286 O2P.t0 VSS 0.34028f
C287 O2P.t2 VSS 0.06654f
C288 O2P.n1 VSS 0.40061f
C289 O2P.t1 VSS 0.12464f
C290 O2P.t4 VSS 0.03786f
C291 O2P.n2 VSS 0.34124f
C292 O2P.n3 VSS 0.04159f
C293 O2P.t3 VSS 0.14892f
C294 O2N.t6 VSS 0.17783f
C295 O2N.t3 VSS 0.14357f
C296 O2N.n0 VSS 2.14188f
C297 O2N.t5 VSS 0.17139f
C298 O2N.t0 VSS 0.37417f
C299 O2N.t4 VSS 0.04164f
C300 O2N.t1 VSS 0.13729f
C301 O2N.n1 VSS 0.36296f
C302 O2N.n2 VSS 0.37408f
C303 O2N.t2 VSS 0.07091f
C304 O2N.n3 VSS 0.07741f
C305 O2N.n4 VSS 1.25074f
C306 O3N.t4 VSS 0.07497f
C307 O3N.t1 VSS 0.3316f
C308 O3N.t5 VSS 0.0369f
C309 O3N.t2 VSS 0.12167f
C310 O3N.n0 VSS 0.32166f
C311 O3N.n1 VSS 0.33152f
C312 O3N.t0 VSS 0.06284f
C313 O3N.n2 VSS 0.0676f
C314 O3N.t6 VSS 0.15725f
C315 O3N.n3 VSS 1.36522f
C316 O3N.n4 VSS 1.74838f
C317 O3N.t3 VSS 0.12739f
C318 O3N.n5 VSS 0.77363f
C319 PRESCALER_CLK.t1 VSS 0.21111f
C320 PRESCALER_CLK.t0 VSS 0.13849f
C321 TAIL_BIAS.t0 VSS 0.03652f
.ends
