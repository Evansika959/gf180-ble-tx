* NGSPICE file created from Phase_Detector_FE_PEX.ext - technology: gf180mcuD

.subckt Phase_Detector_FE_PEX VDD VSS F_REF F_VCO UP DN UPb DNb
X0 VDD F_VCO UPb VDD pfet_03v3 ad=0.728p pd=3.54u as=0.728p ps=3.54u w=1.12u l=0.28u
X1 DNb UP N_DN VSS nfet_03v3 ad=0.3416p pd=2.34u as=0.3416p ps=2.34u w=0.56u l=0.28u
X2 UP UPb VSS VSS nfet_03v3 ad=0.3416p pd=2.34u as=0.3416p ps=2.34u w=0.56u l=0.28u
X3 VDD UPb UP VDD pfet_03v3 ad=0.728p pd=3.54u as=0.728p ps=3.54u w=1.12u l=0.28u
X4 N_UP F_VCO VSS VSS nfet_03v3 ad=0.1456p pd=1.08u as=0.3416p ps=2.34u w=0.56u l=0.28u
X5 UPb F_REF N_UP VSS nfet_03v3 ad=0.3416p pd=2.34u as=0.1456p ps=1.08u w=0.56u l=0.28u
X6 N_DN F_REF VSS VSS nfet_03v3 ad=0.1456p pd=1.08u as=0.3416p ps=2.34u w=0.56u l=0.28u
X7 VDD F_REF DNb VDD pfet_03v3 ad=0.728p pd=3.54u as=0.728p ps=3.54u w=1.12u l=0.28u
X8 VDD DNb DN VDD pfet_03v3 ad=0.728p pd=3.54u as=0.728p ps=3.54u w=1.12u l=0.28u
X9 DNb F_VCO N_DN VSS nfet_03v3 ad=0.3416p pd=2.34u as=0.1456p ps=1.08u w=0.56u l=0.28u
X10 UPb DN N_UP VSS nfet_03v3 ad=0.3416p pd=2.34u as=0.3416p ps=2.34u w=0.56u l=0.28u
X11 DN DNb VSS VSS nfet_03v3 ad=0.3416p pd=2.34u as=0.3416p ps=2.34u w=0.56u l=0.28u
C0 UPb DN 0.13289f
C1 F_REF VDD 0.20131f
C2 N_UP F_VCO 0.0498f
C3 UPb VDD 0.28906f
C4 F_REF F_VCO 0.69662f
C5 F_VCO UPb 0.14919f
C6 DN VDD 0.12378f
C7 UP N_DN 0.00717f
C8 F_VCO DN 0.04776f
C9 F_VCO VDD 0.49581f
C10 N_UP N_DN 0
C11 F_REF N_DN 0.05394f
C12 UP DNb 0.19787f
C13 N_DN VDD 0.00205f
C14 F_VCO N_DN 0.01243f
C15 F_REF DNb 0.11928f
C16 DNb UPb 0.02033f
C17 DNb DN 0.14654f
C18 DNb VDD 0.28845f
C19 UP F_REF 0.07021f
C20 UP UPb 0.15103f
C21 DNb F_VCO 0.05981f
C22 N_UP F_REF 0.02074f
C23 N_UP UPb 0.10977f
C24 UP DN 0.28076f
C25 UP VDD 0.22895f
C26 F_REF UPb 0.02762f
C27 UP F_VCO 0.13812f
C28 N_UP DN 0.00717f
C29 N_UP VDD 0.00205f
C30 F_REF DN 0.07356f
C31 DNb N_DN 0.11044f
C32 UP VSS 0.46174f
C33 DN VSS 0.53959f
C34 UPb VSS 0.58762f
C35 F_VCO VSS 1.215f
C36 DNb VSS 0.58073f
C37 F_REF VSS 1.49625f
C38 VDD VSS 5.58003f
C39 N_UP VSS 0.14452f
C40 N_DN VSS 0.14435f
.ends
