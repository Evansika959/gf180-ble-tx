* NGSPICE file created from 32_33_Prescaler_PEX.ext - technology: gf180mcuD

.subckt x32_33_Prescaler_PEX VDD VSS CLK_IN MC CLK_OUT
X0 NOR_PSTACK Q1 VDD VDD pfet_03v3 ad=0.728p pd=3.54u as=0.728p ps=3.54u w=1.12u l=0.28u
X1 VDD X3_N1 Q4b VDD pfet_03v3 ad=0.728p pd=3.54u as=0.728p ps=3.54u w=1.12u l=0.28u
X2 X1_N2 NOR_OUT VSS VSS nfet_03v3 ad=0.3416p pd=2.34u as=0.3416p ps=2.34u w=0.56u l=0.28u
X3 Q4b Q3 a_8936_412# VSS nfet_03v3 ad=0.3416p pd=2.34u as=0.1456p ps=1.08u w=0.56u l=0.28u
X4 a_4346_3028# Q4b a_4346_2860# VSS nfet_03v3 ad=93.59999f pd=0.88u as=93.59999f ps=0.88u w=0.36u l=0.32u
X5 VSS Q4b a_8188_3004# VSS nfet_03v3 ad=0.3416p pd=2.34u as=0.1456p ps=1.08u w=0.56u l=0.28u
X6 VDD X2_N1 Q3n VDD pfet_03v3 ad=0.728p pd=3.54u as=0.728p ps=3.54u w=1.12u l=0.28u
X7 Q3n CLK_IN a_6398_412# VSS nfet_03v3 ad=0.3416p pd=2.34u as=0.1456p ps=1.08u w=0.56u l=0.28u
X8 VSS X5_N1 a_5388_2996# VSS nfet_03v3 ad=0.3416p pd=2.34u as=0.1456p ps=1.08u w=0.56u l=0.28u
X9 X2_N1 X2_N2 a_5798_404# VSS nfet_03v3 ad=0.3416p pd=2.34u as=0.1456p ps=1.08u w=0.56u l=0.28u
X10 X3_N2 Q4b VSS VSS nfet_03v3 ad=0.3416p pd=2.34u as=0.3416p ps=2.34u w=0.56u l=0.28u
X11 a_8336_404# Q3 VSS VSS nfet_03v3 ad=0.1456p pd=1.08u as=0.3416p ps=2.34u w=0.56u l=0.28u
X12 VDD Q3n Q3 VDD pfet_03v3 ad=0.728p pd=3.54u as=0.728p ps=3.54u w=1.12u l=0.28u
X13 a_7674_1144# Q3 X3_N2 VDD pfet_03v3 ad=0.2912p pd=1.64u as=0.728p ps=3.54u w=1.12u l=0.28u
X14 X2_N2 Q2 VSS VSS nfet_03v3 ad=0.3416p pd=2.34u as=0.3416p ps=2.34u w=0.56u l=0.28u
X15 a_4298_412# X1_N1 VSS VSS nfet_03v3 ad=0.1456p pd=1.08u as=0.3416p ps=2.34u w=0.56u l=0.28u
X16 a_4346_3364# CLK_OUT a_4346_3196# VSS nfet_03v3 ad=93.59999f pd=0.88u as=93.59999f ps=0.88u w=0.36u l=0.32u
X17 a_5136_1144# CLK_IN X2_N2 VDD pfet_03v3 ad=0.2912p pd=1.64u as=0.728p ps=3.54u w=1.12u l=0.28u
X18 a_3698_404# CLK_IN VSS VSS nfet_03v3 ad=0.1456p pd=1.08u as=0.3416p ps=2.34u w=0.56u l=0.28u
X19 VSS CLK_OUT X5_N2 VSS nfet_03v3 ad=0.3416p pd=2.34u as=0.3416p ps=2.34u w=0.56u l=0.28u
X20 VDD NOR_OUT a_3036_1144# VDD pfet_03v3 ad=0.728p pd=3.54u as=0.2912p ps=1.64u w=1.12u l=0.28u
X21 VSS Q3n NOR_OUT VSS nfet_03v3 ad=0.3416p pd=2.34u as=0.3416p ps=2.34u w=0.56u l=0.28u
X22 X5_N2 Q5b a_6538_2264# VDD pfet_03v3 ad=0.728p pd=3.54u as=0.2912p ps=1.64u w=1.12u l=0.28u
X23 a_8936_412# X3_N1 VSS VSS nfet_03v3 ad=0.1456p pd=1.08u as=0.3416p ps=2.34u w=0.56u l=0.28u
X24 VSS Q5b a_5988_3004# VSS nfet_03v3 ad=0.3416p pd=2.34u as=0.1456p ps=1.08u w=0.56u l=0.28u
X25 a_4346_2860# CLK_IN a_4346_2692# VSS nfet_03v3 ad=93.59999f pd=0.88u as=93.59999f ps=0.88u w=0.36u l=0.32u
X26 a_8188_3004# X4_N2 X4_N1 VSS nfet_03v3 ad=0.1456p pd=1.08u as=0.3416p ps=2.34u w=0.56u l=0.28u
X27 X6_DYN Q3n a_4311_1994# VDD pfet_03v3 ad=0.468p pd=2.74u as=0.1872p ps=1.24u w=0.72u l=0.32u
X28 VSS Q1 NOR_OUT VSS nfet_03v3 ad=0.3416p pd=2.34u as=0.3416p ps=2.34u w=0.56u l=0.28u
X29 VSS X4_N1 a_7588_2996# VSS nfet_03v3 ad=0.3416p pd=2.34u as=0.1456p ps=1.08u w=0.56u l=0.28u
X30 a_5388_2996# Q5b CLK_OUT VSS nfet_03v3 ad=0.1456p pd=1.08u as=0.3416p ps=2.34u w=0.56u l=0.28u
X31 NOR_OUT Q3n NOR_PSTACK VDD pfet_03v3 ad=0.728p pd=3.54u as=0.728p ps=3.54u w=1.12u l=0.28u
X32 VDD CLK_IN X2_N1 VDD pfet_03v3 ad=0.728p pd=3.54u as=0.728p ps=3.54u w=1.12u l=0.28u
X33 a_6398_412# X2_N1 VSS VSS nfet_03v3 ad=0.1456p pd=1.08u as=0.3416p ps=2.34u w=0.56u l=0.28u
X34 a_3826_2864# X6_DYN Q1 VSS nfet_03v3 ad=93.59999f pd=0.88u as=0.228p ps=1.98u w=0.36u l=0.36u
X35 a_5798_404# CLK_IN VSS VSS nfet_03v3 ad=0.1456p pd=1.08u as=0.3416p ps=2.34u w=0.56u l=0.28u
X36 a_4346_2692# Q3n X6_DYN VSS nfet_03v3 ad=93.59999f pd=0.88u as=0.228p ps=1.98u w=0.36u l=0.32u
X37 a_6538_2264# CLK_OUT VDD VDD pfet_03v3 ad=0.2912p pd=1.64u as=0.728p ps=3.54u w=1.12u l=0.28u
X38 VDD X1_N1 Q2 VDD pfet_03v3 ad=0.728p pd=3.54u as=0.728p ps=3.54u w=1.12u l=0.28u
X39 Q1 X6_DYN VDD VDD pfet_03v3 ad=0.2432p pd=2.06u as=0.2432p ps=2.06u w=0.36u l=0.36u
X40 X4_N1 Q4b VDD VDD pfet_03v3 ad=0.728p pd=3.54u as=0.728p ps=3.54u w=1.12u l=0.28u
X41 CLK_OUT X5_N1 VDD VDD pfet_03v3 ad=0.728p pd=3.54u as=0.728p ps=3.54u w=1.12u l=0.28u
X42 a_4346_3196# Q5b a_4346_3028# VSS nfet_03v3 ad=93.59999f pd=0.88u as=93.59999f ps=0.88u w=0.36u l=0.32u
X43 VSS Q5b X4_N2 VSS nfet_03v3 ad=0.3416p pd=2.34u as=0.3416p ps=2.34u w=0.56u l=0.28u
X44 X4_N2 Q4b a_8738_2264# VDD pfet_03v3 ad=0.728p pd=3.54u as=0.2912p ps=1.64u w=1.12u l=0.28u
X45 a_3036_1144# CLK_IN X1_N2 VDD pfet_03v3 ad=0.2912p pd=1.64u as=0.728p ps=3.54u w=1.12u l=0.28u
X46 VDD Q3 X3_N1 VDD pfet_03v3 ad=0.728p pd=3.54u as=0.728p ps=3.54u w=1.12u l=0.28u
X47 a_5988_3004# X5_N2 X5_N1 VSS nfet_03v3 ad=0.1456p pd=1.08u as=0.3416p ps=2.34u w=0.56u l=0.28u
X48 X3_N1 X3_N2 a_8336_404# VSS nfet_03v3 ad=0.3416p pd=2.34u as=0.1456p ps=1.08u w=0.56u l=0.28u
X49 a_7588_2996# Q4b Q5b VSS nfet_03v3 ad=0.1456p pd=1.08u as=0.3416p ps=2.34u w=0.56u l=0.28u
X50 a_4311_1994# CLK_IN VDD VDD pfet_03v3 ad=0.1872p pd=1.24u as=0.468p ps=2.74u w=0.72u l=0.32u
X51 VSS CLK_IN a_3826_2864# VSS nfet_03v3 ad=0.228p pd=1.98u as=93.59999f ps=0.88u w=0.36u l=0.36u
X52 VDD Q4b a_7674_1144# VDD pfet_03v3 ad=0.728p pd=3.54u as=0.2912p ps=1.64u w=1.12u l=0.28u
X53 VSS MC a_4346_3364# VSS nfet_03v3 ad=0.228p pd=1.98u as=93.59999f ps=0.88u w=0.36u l=0.32u
X54 X5_N1 Q5b VDD VDD pfet_03v3 ad=0.728p pd=3.54u as=0.728p ps=3.54u w=1.12u l=0.28u
X55 a_8738_2264# Q5b VDD VDD pfet_03v3 ad=0.2912p pd=1.64u as=0.728p ps=3.54u w=1.12u l=0.28u
X56 VDD CLK_IN X1_N1 VDD pfet_03v3 ad=0.728p pd=3.54u as=0.728p ps=3.54u w=1.12u l=0.28u
X57 Q2 CLK_IN a_4298_412# VSS nfet_03v3 ad=0.3416p pd=2.34u as=0.1456p ps=1.08u w=0.56u l=0.28u
X58 Q3 Q3n VSS VSS nfet_03v3 ad=0.3416p pd=2.34u as=0.3416p ps=2.34u w=0.56u l=0.28u
X59 Q5b X4_N1 VDD VDD pfet_03v3 ad=0.728p pd=3.54u as=0.728p ps=3.54u w=1.12u l=0.28u
X60 VDD Q2 a_5136_1144# VDD pfet_03v3 ad=0.728p pd=3.54u as=0.2912p ps=1.64u w=1.12u l=0.28u
X61 X1_N1 X1_N2 a_3698_404# VSS nfet_03v3 ad=0.3416p pd=2.34u as=0.1456p ps=1.08u w=0.56u l=0.28u
C0 Q4b X4_N2 0.26645f
C1 X5_N2 Q4b 0.00181f
C2 X6_DYN a_4346_3196# 0
C3 CLK_IN X5_N1 0.01577f
C4 VDD X5_N1 0.31841f
C5 Q5b CLK_OUT 0.87189f
C6 Q4b a_5988_3004# 0
C7 a_4346_2860# Q1 0
C8 CLK_OUT a_4346_3028# 0
C9 a_8188_3004# Q4b 0
C10 X2_N2 Q4b 0.00186f
C11 Q5b a_4346_3028# 0
C12 NOR_OUT a_3036_1144# 0.00572f
C13 CLK_IN X3_N2 0
C14 VDD X3_N2 0.14595f
C15 CLK_IN a_3036_1144# 0.00943f
C16 X5_N1 a_6538_2264# 0
C17 VDD a_3036_1144# 0.01345f
C18 a_7588_2996# X4_N2 0
C19 Q2 Q4b 0.03246f
C20 X4_N1 X4_N2 0.06165f
C21 X4_N1 X5_N2 0
C22 a_8936_412# Q3 0
C23 a_5136_1144# Q4b 0.00256f
C24 a_4311_1994# X6_DYN 0.00344f
C25 a_4346_2692# Q3n 0.0012f
C26 X4_N1 a_8188_3004# 0.00646f
C27 a_4298_412# NOR_OUT 0
C28 a_3826_2864# Q1 0.00428f
C29 X3_N2 a_8336_404# 0
C30 X5_N1 X5_N2 0.06165f
C31 CLK_IN a_4298_412# 0.00188f
C32 VDD a_4298_412# 0
C33 X3_N2 a_7674_1144# 0.00679f
C34 Q1 X6_DYN 0.13755f
C35 X5_N1 a_5988_3004# 0.00646f
C36 a_4346_2860# Q3n 0
C37 X3_N1 Q5b 0
C38 X5_N1 X2_N2 0
C39 Q1 Q4b 0.00329f
C40 a_3036_1144# X1_N1 0
C41 a_5388_2996# Q4b 0
C42 CLK_OUT a_4346_3364# 0
C43 X2_N1 CLK_OUT 0
C44 X1_N2 NOR_OUT 0.04768f
C45 X2_N1 Q5b 0.0021f
C46 Q3 Q4b 0.90785f
C47 CLK_IN X1_N2 0.26672f
C48 CLK_IN CLK_OUT 0.10512f
C49 VDD X1_N2 0.14839f
C50 VDD CLK_OUT 0.52579f
C51 X2_N1 a_6398_412# 0.00262f
C52 CLK_IN Q5b 0.21743f
C53 VDD Q5b 2.69013f
C54 a_4298_412# X1_N1 0.00262f
C55 a_3826_2864# Q3n 0
C56 CLK_IN a_4346_3028# 0.00165f
C57 VDD a_4346_3028# 0
C58 CLK_IN a_6398_412# 0
C59 VDD a_6398_412# 0.00104f
C60 X6_DYN Q3n 0.24208f
C61 X2_N1 a_5798_404# 0.00646f
C62 a_6538_2264# CLK_OUT 0.00918f
C63 Q3n Q4b 0.80959f
C64 MC Q3n 0
C65 X4_N1 Q3 0.00239f
C66 X5_N1 Q1 0
C67 Q5b a_6538_2264# 0.01253f
C68 X5_N1 a_5388_2996# 0.00262f
C69 CLK_IN a_5798_404# 0
C70 VDD a_5798_404# 0
C71 a_4346_2692# X6_DYN 0.00453f
C72 X1_N2 X1_N1 0.06165f
C73 a_8738_2264# Q4b 0.00943f
C74 a_4298_412# Q2 0.00587f
C75 CLK_OUT X4_N2 0
C76 X5_N2 CLK_OUT 0.06638f
C77 a_4346_2692# Q4b 0
C78 Q5b X5_N2 0.297f
C79 Q5b X4_N2 0.09124f
C80 CLK_OUT a_5988_3004# 0.00211f
C81 VDD X3_N1 0.47385f
C82 NOR_PSTACK NOR_OUT 0.08436f
C83 Q5b a_5988_3004# 0.00342f
C84 X1_N2 a_3698_404# 0
C85 a_4346_2860# X6_DYN 0.0017f
C86 CLK_OUT a_4346_3196# 0
C87 X1_N2 X2_N2 0
C88 Q5b a_8188_3004# 0.00348f
C89 Q5b a_4346_3196# 0
C90 CLK_IN NOR_PSTACK 0.00157f
C91 X3_N2 Q3 0.26645f
C92 Q5b X2_N2 0
C93 VDD NOR_PSTACK 0.15702f
C94 CLK_IN a_4346_3364# 0
C95 a_4346_2860# Q4b 0
C96 VDD a_4346_3364# 0
C97 CLK_IN X2_N1 0.34539f
C98 X4_N1 a_8738_2264# 0
C99 a_8936_412# Q4b 0.00405f
C100 CLK_IN NOR_OUT 0.30996f
C101 VDD X2_N1 0.47772f
C102 Q2 X1_N2 0
C103 X2_N2 a_6398_412# 0
C104 Q2 CLK_OUT 0
C105 VDD NOR_OUT 0.52848f
C106 X5_N1 Q3n 0.00137f
C107 X3_N1 a_8336_404# 0.00646f
C108 CLK_IN VDD 5.23783f
C109 X3_N1 a_7674_1144# 0
C110 Q2 a_6398_412# 0
C111 a_5798_404# X2_N2 0
C112 a_3826_2864# X6_DYN 0
C113 X3_N2 Q3n 0.00121f
C114 X5_N1 a_4346_2692# 0
C115 X3_N1 X4_N2 0
C116 Q3n a_3036_1144# 0
C117 a_3826_2864# Q4b 0
C118 Q2 a_5798_404# 0.00139f
C119 VDD a_6538_2264# 0.01226f
C120 X1_N2 Q1 0
C121 Q1 CLK_OUT 0.00336f
C122 VDD a_8336_404# 0
C123 a_5388_2996# CLK_OUT 0.00868f
C124 NOR_OUT X1_N1 0.03708f
C125 X6_DYN Q4b 0.00922f
C126 MC X6_DYN 0
C127 Q5b Q1 0
C128 X2_N1 X5_N2 0
C129 Q5b a_5388_2996# 0.00299f
C130 a_4346_2860# X5_N1 0
C131 VDD a_7674_1144# 0.01251f
C132 Q1 a_4346_3028# 0
C133 CLK_IN X1_N1 0.36827f
C134 VDD X1_N1 0.48578f
C135 a_4298_412# Q3n 0
C136 CLK_IN X5_N2 0
C137 VDD X5_N2 0.09865f
C138 VDD X4_N2 0.09817f
C139 X2_N1 X2_N2 0.06165f
C140 a_3698_404# NOR_OUT 0.00139f
C141 Q5b Q3 0.03921f
C142 X3_N2 a_8936_412# 0
C143 VDD a_5988_3004# 0
C144 CLK_IN a_4346_3196# 0
C145 CLK_IN a_3698_404# 0
C146 VDD a_8188_3004# 0
C147 CLK_IN X2_N2 0.26719f
C148 VDD a_4346_3196# 0
C149 VDD a_3698_404# 0
C150 a_6398_412# Q3 0
C151 VDD X2_N2 0.14535f
C152 X2_N1 Q2 0.03708f
C153 X2_N1 a_5136_1144# 0
C154 a_7588_2996# Q4b 0
C155 X5_N2 a_6538_2264# 0.00679f
C156 X4_N1 Q4b 0.34881f
C157 CLK_IN Q2 0.422f
C158 X1_N2 Q3n 0.00101f
C159 CLK_OUT Q3n 0.00112f
C160 VDD Q2 0.49971f
C161 a_5798_404# Q3 0
C162 X5_N1 X6_DYN 0.00103f
C163 CLK_IN a_5136_1144# 0.00943f
C164 Q5b Q3n 0.0038f
C165 VDD a_5136_1144# 0.01252f
C166 a_4311_1994# NOR_OUT 0
C167 a_4346_3028# Q3n 0
C168 X5_N1 Q4b 0.01296f
C169 Q3n a_6398_412# 0.00479f
C170 NOR_PSTACK Q1 0.07494f
C171 CLK_IN a_4311_1994# 0.00455f
C172 Q5b a_8738_2264# 0.0102f
C173 VDD a_4311_1994# 0.00984f
C174 X5_N2 a_5988_3004# 0
C175 X3_N1 Q3 0.34539f
C176 a_3698_404# X1_N1 0.00646f
C177 X4_N1 a_7588_2996# 0.00262f
C178 X2_N2 X1_N1 0
C179 Q1 NOR_OUT 0.07069f
C180 a_8188_3004# X4_N2 0
C181 X3_N2 Q4b 0.06116f
C182 a_5798_404# Q3n 0.00103f
C183 CLK_IN Q1 0.06228f
C184 CLK_IN a_5388_2996# 0
C185 VDD Q1 0.478f
C186 VDD a_5388_2996# 0
C187 Q2 X1_N1 0.11836f
C188 a_4346_2860# CLK_OUT 0
C189 X2_N1 Q3 0.0129f
C190 CLK_IN Q3 0.0056f
C191 VDD Q3 2.58343f
C192 Q2 X2_N2 0.04832f
C193 X4_N1 X3_N2 0
C194 NOR_PSTACK Q3n 0.02476f
C195 a_5136_1144# X2_N2 0.00679f
C196 Q3n a_4346_3364# 0
C197 X2_N1 Q3n 0.16352f
C198 NOR_OUT Q3n 0.45326f
C199 a_3826_2864# CLK_OUT 0
C200 Q2 a_5136_1144# 0.00498f
C201 Q3 a_8336_404# 0
C202 CLK_IN Q3n 0.45229f
C203 X5_N2 a_5388_2996# 0
C204 VDD Q3n 1.43316f
C205 CLK_OUT X6_DYN 0
C206 Q3 a_7674_1144# 0.00943f
C207 Q5b X6_DYN 0
C208 X6_DYN a_4346_3028# 0
C209 a_4346_2692# NOR_OUT 0
C210 X3_N1 a_8936_412# 0.00262f
C211 MC CLK_OUT 0.06666f
C212 CLK_OUT Q4b 0.19474f
C213 VDD a_8738_2264# 0.01226f
C214 Q3 X4_N2 0
C215 Q5b Q4b 0.86537f
C216 Q5b MC 0.01369f
C217 CLK_IN a_4346_2692# 0.00256f
C218 a_4346_3028# Q4b 0
C219 VDD a_4346_2692# 0
C220 a_6398_412# Q4b 0
C221 CLK_IN a_4346_2860# 0.00309f
C222 Q3n X1_N1 0.00992f
C223 CLK_OUT a_7588_2996# 0
C224 VDD a_4346_2860# 0
C225 X4_N1 CLK_OUT 0.03986f
C226 VDD a_8936_412# 0.00103f
C227 Q5b a_7588_2996# 0.00828f
C228 X4_N1 Q5b 0.24703f
C229 a_8738_2264# X4_N2 0.00679f
C230 a_3698_404# Q3n 0
C231 Q3n a_4346_3196# 0
C232 X2_N2 Q3n 0.02046f
C233 X5_N1 CLK_OUT 0.27147f
C234 X3_N1 Q4b 0.14624f
C235 NOR_PSTACK X6_DYN 0
C236 X5_N1 Q5b 0.41899f
C237 X6_DYN a_4346_3364# 0
C238 X5_N1 a_4346_3028# 0
C239 CLK_IN a_3826_2864# 0.00123f
C240 Q2 Q3n 0.06227f
C241 VDD a_3826_2864# 0
C242 NOR_OUT X6_DYN 0
C243 MC a_4346_3364# 0
C244 a_5136_1144# Q3n 0.00465f
C245 X2_N1 Q4b 0.03896f
C246 X1_N2 a_3036_1144# 0.00679f
C247 CLK_IN X6_DYN 0.14832f
C248 NOR_OUT Q4b 0
C249 VDD X6_DYN 0.34399f
C250 a_4311_1994# Q3n 0.00365f
C251 CLK_IN MC 0.00105f
C252 CLK_IN Q4b 0.22514f
C253 VDD Q4b 3.43047f
C254 VDD MC 0
C255 a_4298_412# X1_N2 0
C256 Q1 Q3n 0.3119f
C257 Q4b a_8336_404# 0.0021f
C258 X6_DYN X1_N1 0
C259 VDD a_7588_2996# 0
C260 VDD X4_N1 0.31594f
C261 Q4b a_7674_1144# 0.00842f
C262 Q3n Q3 0.3024f
C263 X3_N1 X3_N2 0.06165f
C264 CLK_IN VSS 3.47511f
C265 CLK_OUT VSS 1.39326f
C266 MC VSS 0.24646f
C267 VDD VSS 34.1955f
C268 a_8936_412# VSS 0.00421f
C269 a_8336_404# VSS 0.00747f
C270 a_6398_412# VSS 0.00526f
C271 a_5798_404# VSS 0.00694f
C272 a_4298_412# VSS 0.00459f
C273 a_3698_404# VSS 0.00567f
C274 X3_N2 VSS 0.38308f
C275 X3_N1 VSS 0.55529f
C276 a_7674_1144# VSS 0.00448f
C277 Q3 VSS 1.44224f
C278 X2_N2 VSS 0.37849f
C279 X2_N1 VSS 0.48935f
C280 a_5136_1144# VSS 0.00375f
C281 X1_N2 VSS 0.38243f
C282 Q2 VSS 0.58289f
C283 X1_N1 VSS 0.45478f
C284 a_3036_1144# VSS 0.00337f
C285 a_8738_2264# VSS 0.00299f
C286 a_4311_1994# VSS 0.00233f
C287 a_6538_2264# VSS 0.00366f
C288 NOR_PSTACK VSS 0.07035f
C289 a_4346_2692# VSS 0.00221f
C290 X4_N2 VSS 0.42324f
C291 a_8188_3004# VSS 0.00684f
C292 a_7588_2996# VSS 0.00446f
C293 a_4346_2860# VSS 0.00295f
C294 X6_DYN VSS 0.3577f
C295 X5_N2 VSS 0.42547f
C296 X4_N1 VSS 0.64242f
C297 a_5988_3004# VSS 0.00509f
C298 a_5388_2996# VSS 0.00374f
C299 a_3826_2864# VSS 0.00591f
C300 Q4b VSS 3.14047f
C301 a_4346_3028# VSS 0.00405f
C302 X5_N1 VSS 0.67585f
C303 NOR_OUT VSS 1.11445f
C304 Q1 VSS 0.45489f
C305 Q5b VSS 3.80278f
C306 a_4346_3196# VSS 0.00586f
C307 Q3n VSS 2.00611f
C308 a_4346_3364# VSS 0.00881f
.ends
