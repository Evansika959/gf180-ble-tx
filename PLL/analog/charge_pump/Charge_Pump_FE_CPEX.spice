* NGSPICE file created from Charge_Pump_FE_PEX.ext - technology: gf180mcuD

.subckt Charge_Pump_FE_PEX VDD VSS UPb DN IBIAS OUT
X0 P_BIAS IBIAS a_n712_n618# VSS nfet_03v3 ad=0.728p pd=3.54u as=0.224p ps=1.68u w=1.12u l=1u
X1 a_436_320# P_BIAS OUT VDD pfet_03v3 ad=0.448p pd=2.8u as=1.5456p ps=5.86u w=2.24u l=1u
X2 IBIAS IBIAS a_n62_n618# VSS nfet_03v3 ad=0.728p pd=3.54u as=0.224p ps=1.68u w=1.12u l=1u
X3 a_n62_n618# VDD VSS VSS nfet_03v3 ad=0.224p pd=1.68u as=0.3304p ps=2.3u w=0.56u l=0.28u
X4 VDD VSS a_n824_320# VDD pfet_03v3 ad=0.728p pd=3.54u as=0.448p ps=2.8u w=1.12u l=0.28u
X5 VDD UPb a_436_320# VDD pfet_03v3 ad=0.728p pd=3.54u as=0.448p ps=2.8u w=1.12u l=0.28u
X6 a_548_n618# DN VSS VSS nfet_03v3 ad=0.224p pd=1.68u as=0.3304p ps=2.3u w=0.56u l=0.28u
X7 a_n824_320# P_BIAS P_BIAS VDD pfet_03v3 ad=0.448p pd=2.8u as=1.5456p ps=5.86u w=2.24u l=1u
X8 a_n712_n618# VDD VSS VSS nfet_03v3 ad=0.224p pd=1.68u as=0.3304p ps=2.3u w=0.56u l=0.28u
X9 OUT IBIAS a_548_n618# VSS nfet_03v3 ad=0.728p pd=3.54u as=0.224p ps=1.68u w=1.12u l=1u
C0 DN a_436_320# 0
C1 a_n62_n618# DN 0
C2 VDD UPb 0.17955f
C3 VDD IBIAS 0.22379f
C4 UPb OUT 0.00798f
C5 P_BIAS UPb 0.012f
C6 OUT IBIAS 0.07749f
C7 VDD a_n712_n618# 0.00366f
C8 P_BIAS IBIAS 0.1422f
C9 UPb DN 0.00111f
C10 UPb a_436_320# 0.0028f
C11 a_n824_320# VDD 0.01454f
C12 P_BIAS a_n712_n618# 0.00387f
C13 IBIAS DN 0.02551f
C14 IBIAS a_436_320# 0
C15 a_n62_n618# IBIAS 0.00418f
C16 VDD OUT 0.09097f
C17 a_n824_320# P_BIAS 0.00788f
C18 VDD P_BIAS 0.55118f
C19 VDD a_548_n618# 0.00266f
C20 P_BIAS OUT 0.0556f
C21 VDD DN 0.02812f
C22 OUT a_548_n618# 0.00387f
C23 VDD a_436_320# 0.01428f
C24 VDD a_n62_n618# 0.00455f
C25 OUT DN 0.00625f
C26 UPb IBIAS 0.00721f
C27 OUT a_436_320# 0.00749f
C28 P_BIAS DN 0
C29 a_548_n618# DN 0
C30 DN VSS 0.2399f
C31 IBIAS VSS 1.17041f
C32 OUT VSS 0.18226f
C33 UPb VSS 0.09403f
C34 VDD VSS 6.8355f
C35 a_548_n618# VSS 0.00841f
C36 a_n62_n618# VSS 0.00751f
C37 a_n712_n618# VSS 0.00869f
C38 P_BIAS VSS 0.85657f
C39 a_436_320# VSS 0.00419f
C40 a_n824_320# VSS 0.00874f
.ends
