* Generated by generate_dac_gds.py
* Capacitor-array core only; inverter/testbench elements are excluded.
.subckt capacitive_dac_core VOUT B0 B1 B2 B3 B4 B5 B6 B7
CXC7 VOUT B0 0.05p cap_mim_2f0fF A=25p P=20u
CXC2 VOUT B1 0.1p cap_mim_2f0fF A=50p P=30u
CXC1 VOUT B2 0.2p cap_mim_2f0fF A=100p P=40u
CXC3 VOUT B3 0.4p cap_mim_2f0fF A=200p P=60u
CXC4 VOUT B4 0.8p cap_mim_2f0fF A=400p P=80u
CXC5 VOUT B5 1.6p cap_mim_2f0fF A=800p P=120u
CXC6 VOUT B6 3.2p cap_mim_2f0fF A=1600p P=160u
CXC9 VOUT B7 6.4p cap_mim_2f0fF A=3200p P=240u
.ends capacitive_dac_core
