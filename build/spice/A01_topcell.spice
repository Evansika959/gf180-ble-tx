* A01 BLE/PLL integration, external high-impedance VCO supply follower
.subckt A01_topcell VDD VSS VDD_VCO VCTRL CP_IBIAS TAIL_BIAS VTUNE REF_1M CLK_8M UART_RX RST_N CFG[0] CFG[1] CFG[2] CFG[3] CFG[4] CFG[5] RF_OUT FINE_CODE[0] FINE_CODE[1] FINE_CODE[2] FINE_CODE[3] FINE_CODE[4] FINE_CODE[5] FINE_CODE[6] FINE_CODE[7] CODE_VALID AIR_BIT SYM_STROBE
Xtx VDD VSS AIR_BIT CLK_8M CODE_VALID FINE_CODE[0] FINE_CODE[1] FINE_CODE[2] FINE_CODE[3] FINE_CODE[4] FINE_CODE[5] FINE_CODE[6] FINE_CODE[7] RST_N SYM_STROBE UART_RX ble_tx_uart
Xdivider VDD VSS CFG[0] CFG[1] CFG[2] CFG[3] CFG[4] CFG[5] FB_1M PRESCALED MC RST_N ble_feedback_divider
Xprescaler VDD VSS CORE_CLK MC PRESCALED x32_33_Prescaler_PEX
Xvco VDD_VCO VDD VSS vco_O1P vco_O1N vco_O2P vco_O2N vco_O3P vco_O3N vco_O4P vco_O4N RF_OUT VTUNE TAIL_BIAS CORE_CLK VCO_PEX
Xpfd VDD VSS REF_1M FB_1M pfd_UP DN UPB pfd_DNb Phase_Detector_FE_PEX
Xpump VDD VSS UPB DN CP_IBIAS VCTRL Charge_Pump_FE_PEX
Xloop VCTRL VSS PLL_LOOP_FILTER
.ends A01_topcell
