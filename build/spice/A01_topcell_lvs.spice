* Macro-boundary LVS source with explicit RC filter devices.
.subckt ble_tx_uart VDD VSS clk rst_n uart_rx code_valid air_bit sym_strobe fine_code[0] fine_code[1] fine_code[2] fine_code[3] fine_code[4] fine_code[5] fine_code[6] fine_code[7]
.ends ble_tx_uart
.subckt ble_feedback_divider VDD VSS rst_n clk_prescaled clk_feedback modulus_33 cfg_divider[0] cfg_divider[1] cfg_divider[2] cfg_divider[3] cfg_divider[4] cfg_divider[5]
.ends ble_feedback_divider
.subckt 32_33_Complete_Prescaler VDD VSS CLK_IN MC CLK_OUT
.ends 32_33_Complete_Prescaler
.subckt Differential_VCO_ROUTED VDD VBUF VSS DOUBLE_OUT VTUNE TAIL_BIAS PRESCALER_CLK
.ends Differential_VCO_ROUTED
.subckt Phase_Detector_FE VDD VSS F_REF F_VCO UPb DN
.ends Phase_Detector_FE
.subckt Charge_Pump_FE VDD VSS UPb DN IBIAS OUT
.ends Charge_Pump_FE
.subckt PLL_RZ P N B
Xr P N B ppolyf_u r_width=0.8u r_length=88.055u
.ends PLL_RZ
.subckt PLL_C1 TOP BOTTOM
Xc TOP BOTTOM cap_mim_2f0_m5m6_noshield c_width=25.225u c_length=25.225u
.ends PLL_C1
.subckt PLL_C2_UNIT TOP BOTTOM
Xc0 TOP BOTTOM cap_mim_2f0_m5m6_noshield c_width=23.6u c_length=94.495u
Xc1 TOP BOTTOM cap_mim_2f0_m5m6_noshield c_width=23.6u c_length=94.495u
Xc2 TOP BOTTOM cap_mim_2f0_m5m6_noshield c_width=23.6u c_length=94.495u
Xc3 TOP BOTTOM cap_mim_2f0_m5m6_noshield c_width=23.6u c_length=94.495u
.ends PLL_C2_UNIT

.subckt A01_topcell VDD VSS VDD_VCO VCTRL CP_IBIAS TAIL_BIAS VTUNE REF_1M CLK_8M UART_RX RST_N CFG[0] CFG[1] CFG[2] CFG[3] CFG[4] CFG[5] RF_OUT FINE_CODE[0] FINE_CODE[1] FINE_CODE[2] FINE_CODE[3] FINE_CODE[4] FINE_CODE[5] FINE_CODE[6] FINE_CODE[7] CODE_VALID AIR_BIT SYM_STROBE
Xtx VDD VSS CLK_8M RST_N UART_RX CODE_VALID AIR_BIT SYM_STROBE FINE_CODE[0] FINE_CODE[1] FINE_CODE[2] FINE_CODE[3] FINE_CODE[4] FINE_CODE[5] FINE_CODE[6] FINE_CODE[7] ble_tx_uart
Xdivider VDD VSS RST_N PRESCALED FB_1M MC CFG[0] CFG[1] CFG[2] CFG[3] CFG[4] CFG[5] ble_feedback_divider
Xprescaler VDD VSS CORE_CLK MC PRESCALED 32_33_Complete_Prescaler
Xvco VDD_VCO VDD VSS RF_OUT VTUNE TAIL_BIAS CORE_CLK Differential_VCO_ROUTED
Xpfd VDD VSS REF_1M FB_1M UPB DN Phase_Detector_FE
Xpump VDD VSS UPB DN CP_IBIAS VCTRL Charge_Pump_FE
Xres VCTRL LF_RZ VSS PLL_RZ
Xc1 VSS VCTRL PLL_C1
Xc2_0 VSS LF_RZ PLL_C2_UNIT
Xc2_1 VSS LF_RZ PLL_C2_UNIT
Xc2_2 VSS LF_RZ PLL_C2_UNIT
Xc2_3 VSS LF_RZ PLL_C2_UNIT
Xc2_4 VSS LF_RZ PLL_C2_UNIT
Xc2_5 VSS LF_RZ PLL_C2_UNIT
Xc2_6 VSS LF_RZ PLL_C2_UNIT
Xc2_7 VSS LF_RZ PLL_C2_UNIT
.ends A01_topcell
